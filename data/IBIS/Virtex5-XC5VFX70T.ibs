| / 7\'7
| \ \   Xilinx Inc.
| / /
| \_\/.\   IBIS Models for VIRTEX-5
[IBIS ver]   3.2
[File name]   test.ibs
[File Rev]   2.6
[Date]   Tue November 20 21:57:53 2012
[Source]   Derived from spice models, rev0.20, dated 08/17/2007 using
   hspice 2005.03
[Notes]   Xilinx IBIS file for VIRTEX-5 I/O standards.
   All models are preliminary.
   The version of IBISCHK used is ibischk4.
   Ibis models were generated using S2IBIS3.
[Disclaimer] The data in this file is derived from SPICE simulations using
                 modeling information extracted from the target process. While
                 a great deal of care has been taken to provide information
                 that is accurate, this model is considered preliminary as it
                 has not been verified by actual silicon measurement. Treat the
                 data in this model as preliminary until actual silicon
                 verification is performed.
[Copyright]   Copyright 2007, Xilinx Inc., All rights reserved
|   Component VIRTEX-5
[Component]   VIRTEX-5
[Manufacturer]   Xilinx Inc.
[Package]
|FF1136
|variable   typ   min   max
R_pkg   331.37m   22.22m   1036.83m
L_pkg   3.70nH   0.52nH   10.16nH
C_pkg   2.22pF   0.91pF   5.00pF
[Pin]  signal_name   model_name   R_pin   L_pin   C_pin
A14   LVCMOS25_i   LVCMOS25_S_12
A15   LVCMOS25_o   LVCMOS25_F_12
M5   SSTL2_1_i   SSTL2_I_DCI_I
H14   SSTL2_2_i   SSTL2_II_DCI
L21   SSTL2_1_o   SSTL2_I_DCI_O
H15   SSTL2_2_o   SSTL2_II_DCI
H18   LVDCI_i   LVDCI_25
H17   LVDCI_o   LVDCI_25
U18   VP_0   NC
V17   VN_0   NC
L20   A18   LVCMOS25_F_12
L15   A17   LVCMOS25_F_12
L16   A16   LVCMOS25_F_12
J22   A15_D31   NC
K21   A14_D30   NC
K16   A13_D29   NC
J15   A12_D28   NC
G22   A11_D27   NC
H22   A10_D26   NC
L14   A9_D25   NC
K14   A8_D24   NC
K23   A7_D23   NC
K22   A6_D22   NC
J12   A5_D21   NC
H12   A4_D20   NC
G23   A3_D19   NC
H23   A2_D18   NC
K13   A1_D17   NC
K12   A0_D16   NC
AE13   RS1   LVCMOS25_F_12
AE12   RS0   LVCMOS25_F_12
AF23   A25   LVCMOS25_F_12
AG23   A24   LVCMOS25_F_12
AF13   A23   LVCMOS25_F_12
AG12   A22   LVCMOS25_F_12
AE22   A21   LVCMOS25_F_12
AE23   A20   LVCMOS25_F_12
AE14   FCS_B   LVCMOS25_F_12
AF14   FOE_B_MOSI   NC
AF20   FWE_B   LVCMOS25_F_12
AF21   CSO_B   LVCMOS25_F_12
AF15   D7   LVCMOS25_F_12
AE16   D6   LVCMOS25_F_12
AE21   D5   LVCMOS25_F_12
AD20   D4   LVCMOS25_F_12
AF16   D3   LVCMOS25_F_12
AE17   D2_FS2   NC
AE19   D1_FS1   NC
AD19   D0_FS0   NC
K17   IO_L1P_CC_GC_3   NC
L18   IO_L1N_CC_GC_3   NC
G15   IO_L2P_GC_VRN_3   NC
G16   IO_L2N_GC_VRP_3   NC
K18   IO_L3P_GC_3   NC
J19   IO_L3N_GC_3   NC
J16   IO_L4P_GC_3   NC
J17   IO_L4N_GC_VREF_3   NC
L19   IO_L5P_GC_3   NC
K19   IO_L5N_GC_3   NC
J20   IO_L7P_GC_3   NC
J21   IO_L7N_GC_3   NC
J14   IO_L8P_GC_3   NC
H13   IO_L8N_GC_3   NC
H19   IO_L9P_GC_3   NC
H20   IO_L9N_GC_3   NC
AG22   D15   LVCMOS25_F_12
AH22   D14   LVCMOS25_F_12
AH12   D13   LVCMOS25_F_12
AG13   D12   LVCMOS25_F_12
AH20   D11   LVCMOS25_F_12
AH19   D10   LVCMOS25_F_12
AH14   D9   LVCMOS25_F_12
AH13   D8   LVCMOS25_F_12
AG21   IO_L4P_GC_4   NC
AG20   IO_L4N_GC_VREF_4   NC
AH15   IO_L5P_GC_4   NC
AG15   IO_L5N_GC_4   NC
AG18   IO_L6P_GC_4   NC
AF19   IO_L6N_GC_4   NC
AH17   IO_L7P_GC_VRN_4   NC
AG16   IO_L7N_GC_VRP_4   NC
AF18   IO_L8P_CC_GC_4   NC
AE18   IO_L8N_CC_GC_4   NC
AH18   IO_L9P_CC_GC_4   NC
AG17   IO_L9N_CC_GC_4   NC
B16   IO_L0P_5   NC
B15   IO_L0N_5   NC
B17   IO_L2P_5   NC
A16   IO_L2N_5   NC
C14   IO_L3P_5   NC
C15   IO_L3N_5   NC
E19   IO_L4P_5   NC
F19   IO_L4N_VREF_5   NC
C17   IO_L5P_5   NC
D17   IO_L5N_5   NC
E21   IO_L6P_5   NC
D20   IO_L6N_5   NC
D16   IO_L7P_5   NC
D15   IO_L7N_5   NC
G20   IO_L8P_CC_5   NC
F20   IO_L8N_CC_5   NC
D14   IO_L9P_CC_5   NC
E14   IO_L9N_CC_5   NC
E17   IO_L10P_CC_5   NC
E16   IO_L10N_CC_5   NC
F21   IO_L11P_CC_5   NC
G21   IO_L11N_CC_5   NC
E18   IO_L12P_VRN_5   NC
D19   IO_L12N_VRP_5   NC
D21   IO_L13P_5   NC
D22   IO_L13N_5   NC
F18   IO_L14P_5   NC
G18   IO_L14N_VREF_5   NC
E22   IO_L15P_5   NC
F23   IO_L15N_5   NC
G17   IO_L16P_5   NC
F16   IO_L16N_5   NC
D24   IO_L17P_5   NC
E23   IO_L17N_5   NC
F14   IO_L18P_5   NC
F15   IO_L18N_5   NC
F24   IO_L19P_5   NC
E24   IO_L19N_5   NC
AH24   IO_L0P_6   NC
AJ24   IO_L0N_6   NC
AK12   IO_L1P_6   NC
AJ12   IO_L1N_6   NC
AH23   IO_L2P_6   NC
AJ22   IO_L2N_6   NC
AL13   IO_L3P_6   NC
AK13   IO_L3N_6   NC
AK24   IO_L4P_6   NC
AL23   IO_L4N_VREF_6   NC
AJ14   IO_L5P_6   NC
AK14   IO_L5N_6   NC
AK23   IO_L6P_6   NC
AK22   IO_L6N_6   NC
AL15   IO_L7P_6   NC
AL14   IO_L7N_6   NC
AJ21   IO_L8P_CC_6   NC
AJ20   IO_L8N_CC_6   NC
AJ16   IO_L9P_CC_6   NC
AJ15   IO_L9N_CC_6   NC
AK16   IO_L10P_CC_6   NC
AL16   IO_L10N_CC_6   NC
AL21   IO_L11P_CC_6   NC
AK21   IO_L11N_CC_6   NC
AK17   IO_L12P_VRN_6   NC
AJ17   IO_L12N_VRP_6   NC
AL19   IO_L13P_6   NC
AL20   IO_L13N_6   NC
AK18   IO_L14P_6   NC
AL18   IO_L14N_VREF_6   NC
AJ19   IO_L15P_6   NC
AK19   IO_L15N_6   NC
AM15   IO_L16P_6   NC
AM16   IO_L16N_6   NC
AP16   IO_L17P_6   NC
AP17   IO_L17N_6   NC
AN15   IO_L18P_6   NC
AP15   IO_L18N_6   NC
AM17   IO_L19P_6   NC
AN17   IO_L19N_6   NC
B32   IO_L0P_11   NC
A33   IO_L0N_11   NC
B33   IO_L1P_11   NC
C33   IO_L1N_11   NC
C32   IO_L2P_11   NC
D32   IO_L2N_11   NC
C34   IO_L3P_11   NC
D34   IO_L3N_11   NC
G32   IO_L4P_11   NC
H32   IO_L4N_VREF_11   NC
F33   IO_L5P_11   NC
E34   IO_L5N_11   NC
E32   IO_L6P_11   NC
E33   IO_L6N_11   NC
G33   IO_L7P_11   NC
F34   IO_L7N_11   NC
J32   IO_L8P_CC_11   NC
H33   IO_L8N_CC_11   NC
H34   IO_L9P_CC_11   NC
J34   IO_L9N_CC_11   NC
L34   SM15P   NC
K34   SM15N   NC
K33   SM14P   NC
K32   SM14N   NC
N33   IO_L12P_VRN_11   NC
M33   IO_L12N_VRP_11   NC
L33   IO_L13P_11   NC
M32   IO_L13N_11   NC
P34   IO_L14P_11   NC
N34   IO_L14N_VREF_11   NC
P32   SM13P   NC
N32   SM13N   NC
T33   SM12P   NC
R34   SM12N   NC
R33   SM11P   NC
R32   SM11N   NC
U33   SM10P   NC
T34   SM10N   NC
U32   SM9P   NC
U31   SM9N   NC
M6   IO_L0P_12   NC
N8   IO_L1P_12   NC
N7   IO_L1N_12   NC
M7   IO_L2P_12   NC
L6   IO_L2N_12   NC
N5   IO_L3P_12   NC
P5   IO_L3N_12   NC
L4   IO_L4P_12   NC
L5   IO_L4N_VREF_12   NC
P7   IO_L5P_12   NC
P6   IO_L5N_12   NC
K7   IO_L6P_12   NC
K6   IO_L6N_12   NC
R6   IO_L7P_12   NC
T6   IO_L7N_12   NC
J6   IO_L8P_CC_12   NC
J5   IO_L8N_CC_12   NC
R7   IO_L9P_CC_12   NC
R8   IO_L9N_CC_12   NC
T8   IO_L10P_CC_12   NC
U7   IO_L10N_CC_12   NC
H7   IO_L11P_CC_12   NC
J7   IO_L11N_CC_12   NC
R9   IO_L12P_VRN_12   NC
P9   IO_L12N_VRP_12   NC
H5   IO_L13P_12   NC
G5   IO_L13N_12   NC
R11   IO_L14P_12   NC
P10   IO_L14N_VREF_12   NC
F5   IO_L15P_12   NC
F6   IO_L15N_12   NC
T10   IO_L16P_12   NC
T11   IO_L16N_12   NC
G6   IO_L17P_12   NC
G7   IO_L17N_12   NC
T9   IO_L18P_12   NC
U10   IO_L18N_12   NC
E6   IO_L19P_12   NC
E7   IO_L19N_12   NC
V32   SM8P   NC
V33   SM8N   NC
W34   SM7P   NC
V34   SM7N   NC
Y33   SM6P   NC
AA33   SM6N   NC
AA34   SM5P   NC
Y34   SM5N   NC
Y32   IO_L4P_13   NC
W32   IO_L4N_VREF_13   NC
AC34   SM4P   NC
AD34   SM4N   NC
AC32   SM3P   NC
AB32   SM3N   NC
AC33   SM2P   NC
AB33   SM2N   NC
AF33   SM1P   NC
AE33   SM1N   NC
AF34   SM0P   NC
AE34   SM0N   NC
AH34   IO_L10P_CC_13   NC
AJ34   IO_L10N_CC_13   NC
AD32   IO_L11P_CC_13   NC
AE32   IO_L11N_CC_13   NC
AG33   IO_L12P_VRN_13   NC
AH33   IO_L12N_VRP_13   NC
AK34   IO_L13P_13   NC
AK33   IO_L13N_13   NC
AG32   IO_L14P_13   NC
AH32   IO_L14N_VREF_13   NC
AJ32   IO_L15P_13   NC
AK32   IO_L15N_13   NC
AL34   IO_L16P_13   NC
AL33   IO_L16N_13   NC
AM33   IO_L17P_13   NC
AM32   IO_L17N_13   NC
AN34   IO_L18P_13   NC
AN33   IO_L18N_13   NC
AN32   IO_L19P_13   NC
AP32   IO_L19N_13   NC
E29   IO_L0P_15   NC
F29   IO_L0N_15   NC
G30   IO_L1P_15   NC
F30   IO_L1N_15   NC
H29   IO_L2P_15   NC
J29   IO_L2N_15   NC
F31   IO_L3P_15   NC
E31   IO_L3N_15   NC
L29   IO_L4P_15   NC
K29   IO_L4N_VREF_15   NC
H30   IO_L5P_15   NC
G31   IO_L5N_15   NC
J30   IO_L6P_15   NC
J31   IO_L6N_15   NC
L30   IO_L7P_15   NC
M30   IO_L7N_15   NC
N29   IO_L8P_CC_15   NC
P29   IO_L8N_CC_15   NC
K31   IO_L9P_CC_15   NC
L31   IO_L9N_CC_15   NC
P31   IO_L10P_CC_15   NC
P30   IO_L10N_CC_15   NC
M31   IO_L11P_CC_15   NC
N30   IO_L11N_CC_15   NC
R28   IO_L12P_VRN_15   NC
R29   IO_L12N_VRP_15   NC
T31   IO_L13P_15   NC
R31   IO_L13N_15   NC
U30   IO_L14P_15   NC
T30   IO_L14N_VREF_15   NC
T28   IO_L15P_15   NC
T29   IO_L15N_15   NC
U27   IO_L16P_15   NC
U28   IO_L16N_15   NC
R26   IO_L17P_15   NC
R27   IO_L17N_15   NC
U26   IO_L18P_15   NC
T26   IO_L18N_15   NC
U25   IO_L19P_15   NC
T25   IO_L19N_15   NC
W24   IO_L0P_17   NC
V24   IO_L0N_17   NC
Y26   IO_L1P_17   NC
W26   IO_L1N_17   NC
V25   IO_L2P_17   NC
W25   IO_L2N_17   NC
Y27   IO_L3P_17   NC
W27   IO_L3N_17   NC
V30   IO_L4P_17   NC
W30   IO_L4N_VREF_17   NC
V28   IO_L5P_17   NC
V27   IO_L5N_17   NC
W31   IO_L6P_17   NC
Y31   IO_L6N_17   NC
W29   IO_L7P_17   NC
V29   IO_L7N_17   NC
Y28   IO_L8P_CC_17   NC
Y29   IO_L8N_CC_17   NC
AB31   IO_L9P_CC_17   NC
AA31   IO_L9N_CC_17   NC
AB30   IO_L10P_CC_17   NC
AC30   IO_L10N_CC_17   NC
AA29   IO_L11P_CC_17   NC
AA30   IO_L11N_CC_17   NC
AD31   IO_L12P_VRN_17   NC
AE31   IO_L12N_VRP_17   NC
AD30   IO_L13P_17   NC
AC29   IO_L13N_17   NC
AF31   IO_L14P_17   NC
AG31   IO_L14N_VREF_17   NC
AE29   IO_L15P_17   NC
AD29   IO_L15N_17   NC
AJ31   IO_L16P_17   NC
AK31   IO_L16N_17   NC
AF29   IO_L17P_17   NC
AF30   IO_L17N_17   NC
AJ30   IO_L18P_17   NC
AH30   IO_L18N_17   NC
AH29   IO_L19P_17   NC
AG30   IO_L19N_17   NC
AC4   IO_L0P_18   NC
AC5   IO_L0N_18   NC
AB6   IO_L1P_18   NC
AB7   IO_L1N_18   NC
AA5   IO_L2P_18   NC
AB5   IO_L2N_18   NC
AC7   IO_L3P_18   NC
AD7   IO_L3N_18   NC
Y8   IO_L4P_18   NC
Y9   IO_L4N_VREF_18   NC
AD4   IO_L5P_18   NC
AD5   IO_L5N_18   NC
AA6   IO_L6P_18   NC
Y7   IO_L6N_18   NC
AD6   IO_L7P_18   NC
AE6   IO_L7N_18   NC
W6   IO_L8P_CC_18   NC
Y6   IO_L8N_CC_18   NC
AE7   IO_L9P_CC_18   NC
AF6   IO_L9N_CC_18   NC
AG5   IO_L10P_CC_18   NC
AF5   IO_L10N_CC_18   NC
W7   IO_L11P_CC_18   NC
V7   IO_L11N_CC_18   NC
AH5   IO_L12P_VRN_18   NC
AG6   IO_L12N_VRP_18   NC
Y11   IO_L13P_18   NC
W11   IO_L13N_18   NC
AH7   IO_L14P_18   NC
AG7   IO_L14N_VREF_18   NC
W10   IO_L15P_18   NC
W9   IO_L15N_18   NC
AJ7   IO_L16P_18   NC
AJ6   IO_L16N_18   NC
V8   IO_L17P_18   NC
U8   IO_L17N_18   NC
AK7   IO_L18P_18   NC
AK6   IO_L18N_18   NC
V10   IO_L19P_18   NC
V9   IO_L19N_18   NC
K24   IO_L0P_19   NC
L24   IO_L0N_19   NC
L25   IO_L1P_19   NC
L26   IO_L1N_19   NC
J24   IO_L2P_19   NC
J25   IO_L2N_19   NC
M25   IO_L3P_19   NC
M26   IO_L3N_19   NC
J27   IO_L4P_19   NC
J26   IO_L4N_VREF_19   NC
G25   IO_L5P_19   NC
G26   IO_L5N_19   NC
H25   IO_L6P_19   NC
H24   IO_L6N_19   NC
F25   IO_L7P_19   NC
F26   IO_L7N_19   NC
G27   IO_L8P_CC_19   NC
H27   IO_L8N_CC_19   NC
H28   IO_L9P_CC_19   NC
G28   IO_L9N_CC_19   NC
E28   IO_L10P_CC_19   NC
F28   IO_L10N_CC_19   NC
E26   IO_L11P_CC_19   NC
E27   IO_L11N_CC_19   NC
N27   IO_L12P_VRN_19   NC
M27   IO_L12N_VRP_19   NC
K28   IO_L13P_19   NC
L28   IO_L13N_19   NC
K27   IO_L14P_19   NC
K26   IO_L14N_VREF_19   NC
M28   IO_L15P_19   NC
N28   IO_L15N_19   NC
P26   IO_L16P_19   NC
P27   IO_L16N_19   NC
N24   IO_L17P_19   NC
P24   IO_L17N_19   NC
P25   IO_L18P_19   NC
N25   IO_L18N_19   NC
R24   IO_L19P_19   NC
T24   IO_L19N_19   NC
E9   IO_L0P_20   NC
E8   IO_L0N_20   NC
F9   IO_L1P_20   NC
F8   IO_L1N_20   NC
F10   IO_L2P_20   NC
G10   IO_L2N_20   NC
G8   IO_L3P_20   NC
H8   IO_L3N_20   NC
D11   IO_L4P_20   NC
D10   IO_L4N_VREF_20   NC
K11   IO_L5P_20   NC
J11   IO_L5N_20   NC
D12   IO_L6P_20   NC
C12   IO_L6N_20   NC
H10   IO_L7P_20   NC
H9   IO_L7N_20   NC
A13   IO_L8P_CC_20   NC
B12   IO_L8N_CC_20   NC
J10   IO_L9P_CC_20   NC
J9   IO_L9N_CC_20   NC
K8   IO_L10P_CC_20   NC
K9   IO_L10N_CC_20   NC
B13   IO_L11P_CC_20   NC
C13   IO_L11N_CC_20   NC
L10   IO_L12P_VRN_20   NC
L11   IO_L12N_VRP_20   NC
G11   IO_L13P_20   NC
G12   IO_L13N_20   NC
M8   IO_L14P_20   NC
L8   IO_L14N_VREF_20   NC
F11   IO_L15P_20   NC
E11   IO_L15N_20   NC
M10   IO_L16P_20   NC
L9   IO_L16N_20   NC
E12   IO_L17P_20   NC
E13   IO_L17N_20   NC
N10   IO_L18P_20   NC
N9   IO_L18N_20   NC
F13   IO_L19P_20   NC
G13   IO_L19N_20   NC
AA25   IO_L0P_21   NC
AA26   IO_L0N_21   NC
AB27   IO_L1P_21   NC
AC27   IO_L1N_21   NC
Y24   IO_L2P_21   NC
AA24   IO_L2N_21   NC
AB25   IO_L3P_21   NC
AB26   IO_L3N_21   NC
AC28   IO_L4P_21   NC
AD27   IO_L4N_VREF_21   NC
AB28   IO_L5P_21   NC
AA28   IO_L5N_21   NC
AG28   IO_L6P_21   NC
AH28   IO_L6N_21   NC
AE28   IO_L7P_21   NC
AF28   IO_L7N_21   NC
AK26   IO_L8P_CC_21   NC
AJ27   IO_L8N_CC_21   NC
AK29   IO_L9P_CC_21   NC
AJ29   IO_L9N_CC_21   NC
AK28   IO_L10P_CC_21   NC
AK27   IO_L10N_CC_21   NC
AH27   IO_L11P_CC_21   NC
AJ26   IO_L11N_CC_21   NC
AJ25   IO_L12P_VRN_21   NC
AH25   IO_L12N_VRP_21   NC
AF24   IO_L13P_21   NC
AG25   IO_L13N_21   NC
AG27   IO_L14P_21   NC
AG26   IO_L14N_VREF_21   NC
AF25   IO_L15P_21   NC
AF26   IO_L15N_21   NC
AE27   IO_L16P_21   NC
AE26   IO_L16N_21   NC
AC25   IO_L17P_21   NC
AC24   IO_L17N_21   NC
AD26   IO_L18P_21   NC
AD25   IO_L18N_21   NC
AD24   IO_L19P_21   NC
AE24   IO_L19N_21   NC
AN14   IO_L0P_22   NC
AP14   IO_L0N_22   NC
AB10   IO_L1P_22   NC
AA10   IO_L1N_22   NC
AN13   IO_L2P_22   NC
AM13   IO_L2N_22   NC
AA8   IO_L3P_22   NC
AA9   IO_L3N_22   NC
AP12   IO_L4P_22   NC
AN12   IO_L4N_VREF_22   NC
AC8   IO_L5P_22   NC
AB8   IO_L5N_22   NC
AM12   IO_L6P_22   NC
AM11   IO_L6N_22   NC
AC10   IO_L7P_22   NC
AC9   IO_L7N_22   NC
AL11   IO_L8P_CC_22   NC
AL10   IO_L8N_CC_22   NC
AE8   IO_L9P_CC_22   NC
AD9   IO_L9N_CC_22   NC
AD10   IO_L10P_CC_22   NC
AD11   IO_L10N_CC_22   NC
AK11   IO_L11P_CC_22   NC
AJ11   IO_L11N_CC_22   NC
AF8   IO_L12P_VRN_22   NC
AE9   IO_L12N_VRP_22   NC
AK8   IO_L13P_22   NC
AK9   IO_L13N_22   NC
AF9   IO_L14P_22   NC
AF10   IO_L14N_VREF_22   NC
AJ9   IO_L15P_22   NC
AJ10   IO_L15N_22   NC
AF11   IO_L16P_22   NC
AE11   IO_L16N_22   NC
AH9   IO_L17P_22   NC
AH10   IO_L17N_22   NC
AG8   IO_L18P_22   NC
AH8   IO_L18N_22   NC
AG10   IO_L19P_22   NC
AG11   IO_L19N_22   NC
C20   IO_L0P_23   NC
B20   IO_L0N_23   NC
B21   IO_L1P_23   NC
A21   IO_L1N_23   NC
C19   IO_L2P_23   NC
C18   IO_L2N_23   NC
C22   IO_L3P_23   NC
B22   IO_L3N_23   NC
B18   IO_L4P_23   NC
A18   IO_L4N_VREF_23   NC
C23   IO_L5P_23   NC
B23   IO_L5N_23   NC
A19   IO_L6P_23   NC
A20   IO_L6N_23   NC
A23   IO_L7P_23   NC
A24   IO_L7N_23   NC
C24   IO_L8P_CC_23   NC
D25   IO_L8N_CC_23   NC
B26   IO_L9P_CC_23   NC
A25   IO_L9N_CC_23   NC
B27   IO_L10P_CC_23   NC
A26   IO_L10N_CC_23   NC
B25   IO_L11P_CC_23   NC
C25   IO_L11N_CC_23   NC
C29   IO_L12P_VRN_23   NC
B28   IO_L12N_VRP_23   NC
D26   IO_L13P_23   NC
C27   IO_L13N_23   NC
A29   IO_L14P_23   NC
A28   IO_L14N_VREF_23   NC
C28   IO_L15P_23   NC
D27   IO_L15N_23   NC
B31   IO_L16P_23   NC
A31   IO_L16N_23   NC
C30   IO_L17P_23   NC
D29   IO_L17N_23   NC
D31   IO_L18P_23   NC
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[Package Model]   ff1136_xc5vfx70t
[Diff Pin]   inv_pin   vdiff   tdelay_typ   tdelay_min   tdelay_max
[Series Pin Mapping] pin_2   model_name   function_table_group
[Define Package Model]   ff1136_xc5vfx70t
[Manufacturer]   Xilinx Inc.
[OEM]   Xilinx_K1
[Description]   1136 ball organic flip-chip
[Number Of Pins]   803
[Pin Numbers]
AL25   | 1   AL25  D1.1326   IO_L11P_CC_25
U31   | 2   U31   D1.377   IO_L19N_SM9N_11
AH2   | 3   AH2   D1.1661   MGTTXN1_118
AK16   | 4   AK16  D1.292   IO_L10P_CC_6
AH20   | 5   AH20  D1.164   IO_L2P_GC_D11_4
H19   | 6   H19   D1.145   IO_L9P_GC_3
E17   | 7   E17   D1.226   IO_L10P_CC_5
T2   | 8   T2   D1.1466   MGTTXN1_112
J29   | 9   J29   D1.606   IO_L2N_15
L6   | 10   L6   D1.396   IO_L2N_12
K2   | 11   K2   D1.1596   MGTTXN1_116
AB2   | 12   AB2   D1.1531   MGTTXN1_114
V4   | 13   V4   D1.1493   MGTRREF_112
H23   | 14   H23   D1.78   IO_L8N_CC_A2_D18_1
B10   | 15   B10   D1.1819   MGTTXP0_124
AG7   | 16   AG7   D1.850   IO_L14N_VREF_18
J30   | 17   J30   D1.613   IO_L6P_15
AC33   | 18   AC33  D1.477   IO_L7P_SM2P_13
AD7   | 19   AD7   D1.812   IO_L3N_18
W27   | 20   W27   D1.746   IO_L3N_17
E31   | 21   E31   D1.608   IO_L3N_15
T33   | 22   T33   D1.370   IO_L16P_SM12P_11
P5   | 23   P5   D1.398   IO_L3N_12
D34   | 24   D34   D1.332   IO_L3N_11
H15   | 25   H15   D1.140   IO_L6N_GC_3
AJ20   | 26   AJ20  D1.276   IO_L8N_CC_6
F20   | 27   F20   D1.210   IO_L8N_CC_5
W7   | 28   W7   D1.843   IO_L11P_CC_18
M22   | 29   M22   D1.26   PROGRAM_B_0
AF3   | 30   AF3   D1.1653   MGTREFCLKN_118
P4   | 31   P4   D1.1465   MGTREFCLKP_112
H13   | 32   H13   D1.144   IO_L8N_GC_3
N27   | 33   N27   D1.914   IO_L12P_VRN_19
AH5   | 34   AH5   D1.845   IO_L12P_VRN_18
H4   | 35   H4   D1.1595   MGTREFCLKP_116
Y4   | 36   Y4   D1.1530   MGTREFCLKP_114
AG27   | 37   AG27  D1.1056   IO_L14P_21
M8   | 38   M8   D1.987   IO_L14P_20
N33   | 39   N33   D1.362   IO_L12P_VRN_11
AF9   | 40   AF9   D1.1125   IO_L14P_22
AD31   | 41   AD31  D1.776   IO_L12P_VRN_17
R28   | 42   R28   D1.638   IO_L12P_VRN_15
K34   | 43   K34   D1.359   IO_L10N_CC_SM15N_11
AB5   | 44   AB5   D1.810   IO_L2N_18
J25   | 45   J25   D1.882   IO_L2N_19
M7   | 46   M7   D1.395   IO_L2P_12
AA5   | 47   AA5   D1.809   IO_L2P_18
W25   | 48   W25   D1.744   IO_L2N_17
U8   | 49   U8   D1.856   IO_L17N_18
L28   | 50   L28   D1.917   IO_L13N_19
V33   | 51   V33   D1.464   IO_L0N_SM8N_13
AH21   | 52   AH21  A14.2   VCCO_2
D23   | 53   D23   A4.2   VCCO_3
AG14   | 54   AG14  A16.2   VCCO_4
B19   | 55   B19   A3.2   VCCO_5
AD15   | 56   AD15  D1.59   D_OUT_BUSY_0
AJ27   | 57   AJ27  D1.1032   IO_L8N_CC_21
B12   | 58   B12   D1.960   IO_L8N_CC_20
D25   | 59   D25   D1.1170   IO_L8N_CC_23
G5   | 60   G5   D1.434   IO_L13N_12
AM25   | 61   AM25  D1.1308   IO_L8N_CC_25
G30   | 62   G30   D1.603   IO_L1P_15
AC29   | 63   AC29  D1.779   IO_L13N_17
AB32   | 64   AB32  D1.476   IO_L6N_SM3N_13
AE3   | 65   AE3   D1.1635   MGTAVTTRX_118
W3   | 66   W3   D1.1505   MGTAVTTRX_114
D32   | 67   D32   D1.330   IO_L2N_11
N3   | 68   N3   D1.1440   MGTAVTTRX_112
G1   | 69   G1   D1.1568   MGTRXP0_116
D17   | 70   D17   D1.204   IO_L5N_5
W1   | 71   W1   D1.1503   MGTRXP0_114
N1   | 72   N1   D1.1438   MGTRXP0_112
AE1   | 73   AE1   D1.1633   MGTRXP0_118
AK14   | 74   AK14  D1.270   IO_L5N_6
AP3   | 75   AP3   D1.1787   MGTRXP1_122
AE16   | 76   AE16  D1.107   IO_L6N_D6_2
AG23   | 77   AG23  D1.97   IO_L1N_CC_A24_2
AP9   | 78   AP9   D1.1915   MGTRXP1_126
A6   | 79   A6   D1.1851   MGTRXP1_124
J26   | 80   J26   D1.886   IO_L4N_VREF_19
Y9   | 81   Y9   D1.814   IO_L4N_VREF_18
U17   | 82   U17   D1.19   VREFN_0
V30   | 83   V30   D1.747   IO_L4P_17
W32   | 84   W32   D1.472   IO_L4N_VREF_13
L5   | 85   L5   D1.400   IO_L4N_VREF_12
H32   | 86   H32   D1.334   IO_L4N_VREF_11
W30   | 87   W30   D1.748   IO_L4N_VREF_17
K29   | 88   K29   D1.610   IO_L4N_VREF_15
AN9   | 89   AN9   D1.1919   MGTTXN1_126
E13   | 90   E13   D1.994   IO_L17N_20
AC24   | 91   AC24  D1.1063   IO_L17N_21
AB15   | 92   AB15  D1.51   TCK_0
D29   | 93   D29   D1.1201   IO_L17N_23
AC9   | 94   AC9   D1.1096   IO_L7N_22
AM18   | 95   AM18  D1.1339   IO_L17N_25
H9   | 96   H9   D1.958   IO_L7N_20
AF28   | 97   AF28  D1.1030   IO_L7N_21
B18   | 98   B18   D1.1161   IO_L4P_23
AP12   | 99   AP12  D1.1089   IO_L4P_22
AC28   | 100   AC28  D1.1023   IO_L4P_21
D11   | 101   D11   D1.951   IO_L4P_20
N15   | 102   N15   D1.30   CCLK_0
U18   | 103   U18   D1.16   VP_0
AG30   | 104   AG30  D1.791   IO_L19N_17
T25   | 105   T25   D1.653   IO_L19N_15
AP32   | 106   AP32  D1.515   IO_L19N_13
E7   | 107   E7   D1.446   IO_L19N_12
G23   | 108   G23   D1.77   IO_L8P_CC_A3_D19_1
T24   | 109   T24   D1.929   IO_L19N_19
V9   | 110   V9   D1.860   IO_L19N_18
AE21   | 111   AE21  D1.108   IO_L7P_D5_2
D13   | 112   D13   A2.2   VCCO_1
AD9   | 113   AD9   D1.1100   IO_L9N_CC_22
AA34   | 114   AA34  D1.469   IO_L3P_SM5P_13
AC3   | 115   AC3   D1.1498   MGTAVTTTX_114
P15   | 116   P15   D1.28   D_IN_0
AD3   | 117   AD3   D1.1628   MGTAVTTTX_118
J9   | 118   J9   D1.962   IO_L9N_CC_20
AF8   | 119   AF8   D1.1121   IO_L12P_VRN_22
C34   | 120   C34   D1.331   IO_L3P_11
L10   | 121   L10   D1.983   IO_L12P_VRN_20
AJ25   | 122   AJ25  D1.1052   IO_L12P_VRN_21
AF23   | 123   AF23  D1.96   IO_L1P_CC_A25_2
M26   | 124   M26   D1.884   IO_L3N_19
AG12   | 125   AG12  D1.99   IO_L2N_A22_2
AN24   | 126   AN24  D1.1328   IO_L12P_VRN_25
U7   | 127   U7   D1.428   IO_L10N_CC_12
AJ34   | 128   AJ34  D1.497   IO_L10N_CC_13
AC30   | 129   AC30  D1.773   IO_L10N_CC_17
P30   | 130   P30   D1.635   IO_L10N_CC_15
AF19   | 131   AF19  D1.173   IO_L6N_GC_4
U25   | 132   U25   D1.652   IO_L19P_15
F31   | 133   F31   D1.607   IO_L3P_15
G18   | 134   G18   D1.235   IO_L14N_VREF_5
AL18   | 135   AL18  D1.301   IO_L14N_VREF_6
AJ16   | 136   AJ16  D1.277   IO_L9P_CC_6
AB23   | 137   AB23  D1.38   VFS_0
AM20   | 138   AM20  D1.1331   IO_L13N_25
B5   | 139   B5   D1.1860   MGTTXP1_124
M9   | 140   M9   A20.2   VCCO_12
AA32   | 141   AA32  A10.2   VCCO_13
R30   | 142   R30   A8.2   VCCO_11
AD33   | 143   AD33  A11.2   VCCO_17
L15   | 144   L15   D1.63   IO_L1P_A17_1
L32   | 145   L32   A7.2   VCCO_15
AN15   | 146   AN15  D1.308   IO_L18P_6
A25   | 147   A25   D1.1172   IO_L9N_CC_23
AB9   | 148   AB9   A18.2   VCCO_18
F14   | 149   F14   D1.242   IO_L18P_5
AL26   | 150   AL26  D1.1310   IO_L9N_CC_25
L34   | 151   L34   D1.358   IO_L10P_CC_SM15P_11
AN28   | 152   AN28  D1.1305   IO_L7P_25
AG22   | 153   AG22  D1.160   IO_L0P_GC_D15_4
F13   | 154   F13   D1.997   IO_L19P_20
U2   | 155   U2   D1.1471   MGTTXP1_112
AC2   | 156   AC2   D1.1536   MGTTXP1_114
L2   | 157   L2   D1.1601   MGTTXP1_116
AJ2   | 158   AJ2   D1.1666   MGTTXP1_118
C10   | 159   C10   D1.1822   MGTAVTTTX_124
AE28   | 160   AE28  D1.1029   IO_L7P_21
AP16   | 161   AP16  D1.306   IO_L17P_6
D24   | 162   D24   D1.240   IO_L17P_5
AB33   | 163   AB33  D1.478   IO_L7N_SM2N_13
L8   | 164   L8   D1.988   IO_L14N_VREF_20
AG26   | 165   AG26  D1.1057   IO_L14N_VREF_21
AF10   | 166   AF10  D1.1126   IO_L14N_VREF_22
A28   | 167   A28   D1.1195   IO_L14N_VREF_23
AM23   | 168   AM23  D1.1333   IO_L14N_VREF_25
AJ32   | 169   AJ32  D1.506   IO_L15P_13
F5   | 170   F5   D1.437   IO_L15P_12
T28   | 171   T28   D1.644   IO_L15P_15
AE29   | 172   AE29  D1.782   IO_L15P_17
M28   | 173   M28   D1.920   IO_L15P_19
W10   | 174   W10   D1.851   IO_L15P_18
AD22   | 175   AD22  D1.55   M2_0
Y34   | 176   Y34   D1.470   IO_L3N_SM5N_13
E22   | 177   E22   D1.236   IO_L15P_5
AJ19   | 178   AJ19  D1.302   IO_L15P_6
K21   | 179   K21   D1.66   IO_L2N_A14_D30_1
H33   | 180   H33   D1.342   IO_L8N_CC_11
J5   | 181   J5   D1.408   IO_L8N_CC_12
C20   | 182   C20   D1.1153   IO_L0P_23
P29   | 183   P29   D1.618   IO_L8N_CC_15
AA25   | 184   AA25  D1.1015   IO_L0P_21
E9   | 185   E9   D1.943   IO_L0P_20
Y6   | 186   Y6   D1.822   IO_L8N_CC_18
H27   | 187   H27   D1.894   IO_L8N_CC_19
A29   | 188   A29   D1.1194   IO_L14P_23
D3   | 189   D3   D1.1706   MGTAVCCPLL_120
AM4   | 190   AM4   D1.1771   MGTAVCCPLL_122
AH17   | 191   AH17  D1.174   IO_L7P_GC_VRN_4
C6   | 192   C6   D1.1835   MGTAVCCPLL_124
AM9   | 193   AM9   D1.1899   MGTAVCCPLL_126
AP6   | 194   AP6   D1.1891   MGTRXP0_126
A9   | 195   A9   D1.1827   MGTRXP0_124
AK18   | 196   AK18  D1.300   IO_L14P_6
AL1   | 197   AL1   D1.1763   MGTRXP0_122
A3   | 198   A3   D1.1698   MGTRXP0_120
AF1   | 199   AF1   D1.1640   MGTRXN0_118
Y1   | 200   Y1   D1.1510   MGTRXN0_114
AE18   | 201   AE18  D1.177   IO_L8N_CC_GC_4
P1   | 202   P1   D1.1445   MGTRXN0_112
AK7   | 203   AK7   D1.857   IO_L18P_18
P25   | 204   P25   D1.926   IO_L18P_19
K1   | 205   K1   D1.1592   MGTRXP1_116
AB1   | 206   AB1   D1.1527   MGTRXP1_114
T9   | 207   T9   D1.443   IO_L18P_12
AN34   | 208   AN34  D1.512   IO_L18P_13
U26   | 209   U26   D1.650   IO_L18P_15
AJ30   | 210   AJ30  D1.788   IO_L18P_17
AN12   | 211   AN12  D1.1090   IO_L4N_VREF_22
A18   | 212   A18   D1.1162   IO_L4N_VREF_23
D10   | 213   D10   D1.952   IO_L4N_VREF_20
AD27   | 214   AD27  D1.1024   IO_L4N_VREF_21
AL28   | 215   AL28  D1.1300   IO_L4N_VREF_25
K32   | 216   K32   D1.361   IO_L11N_CC_SM14N_11
K12   | 217   K12   D1.80   IO_L9N_CC_A0_D16_1
D20   | 218   D20   D1.206   IO_L6N_5
C18   | 219   C18   D1.1158   IO_L2N_23
AM13   | 220   AM13  D1.1086   IO_L2N_22
AA24   | 221   AA24  D1.1020   IO_L2N_21
G10   | 222   G10   D1.948   IO_L2N_20
AK22   | 223   AK22  D1.272   IO_L6N_6
AM30   | 224   AM30  D1.1296   IO_L2N_25
AP19   | 225   AP19  D1.1343   IO_L19N_25
AG11   | 226   AG11  D1.1136   IO_L19N_22
AB31   | 227   AB31  D1.757   IO_L9P_CC_17
G13   | 228   G13   D1.998   IO_L19N_20
AE24   | 229   AE24  D1.1067   IO_L19N_21
F24   | 230   F24   D1.244   IO_L19P_5
M15   | 231   M15   D1.29   DONE_0
A20   | 232   A20   D1.1166   IO_L6N_23
R32   | 233   R32   D1.373   IO_L17N_SM11N_11
C12   | 234   C12   D1.956   IO_L6N_20
AH24   | 235   AH24  D1.259   IO_L0P_6
Y33   | 236   Y33   D1.467   IO_L2P_SM6P_13
AB11   | 237   AB11  A19.2   VCCAUX
AK32   | 238   AK32  D1.507   IO_L15N_13
AD19   | 239   AD19  D1.113   IO_L9N_D0_FS0_2
AC22   | 240   AC22  D1.56   M1_0
AD29   | 241   AD29  D1.783   IO_L15N_17
T29   | 242   T29   D1.645   IO_L15N_15
N28   | 243   N28   D1.921   IO_L15N_19
W9   | 244   W9   D1.852   IO_L15N_18
AH7   | 245   AH7   D1.849   IO_L14P_18
E16   | 246   E16   D1.227   IO_L10N_CC_5
AL16   | 247   AL16  D1.293   IO_L10N_CC_6
U30   | 248   U30   D1.642   IO_L14P_15
C22   | 249   C22   D1.1159   IO_L3P_23
AF31   | 250   AF31  D1.780   IO_L14P_17
AE32   | 251   AE32  D1.499   IO_L11N_CC_13
P34   | 252   P34   D1.366   IO_L14P_11
R11   | 253   R11   D1.435   IO_L14P_12
AG32   | 254   AG32  D1.504   IO_L14P_13
AF29   | 255   AF29  D1.786   IO_L17P_17
R26   | 256   R26   D1.648   IO_L17P_15
P6   | 257   P6   D1.402   IO_L5N_12
AM33   | 258   AM33  D1.510   IO_L17P_13
G6   | 259   G6   D1.441   IO_L17P_12
AG13   | 260   AG13  D1.163   IO_L1N_GC_D12_4
R33   | 261   R33   D1.372   IO_L17P_SM11P_11
N24   | 262   N24   D1.924   IO_L17P_19
V8   | 263   V8   D1.855   IO_L17P_18
AG33   | 264   AG33  D1.500   IO_L12P_VRN_13
R9   | 265   R9   D1.431   IO_L12P_VRN_12
C26   | 266   C26   A5.2   VCCO_23
AF7   | 267   AF7   A17.2   VCCO_22
AJ28   | 268   AJ28  A12.2   VCCO_21
E10   | 269   E10   A1.2   VCCO_20
E30   | 270   E30   A6.2   VCCO_19
AF4   | 271   AF4   D1.1660   MGTREFCLKP_118
AK25   | 272   AK25  A13.2   VCCO_25
K18   | 273   K18   D1.133   IO_L3P_GC_3
U10   | 274   U10   D1.444   IO_L18N_12
AN23   | 275   AN23  D1.1332   IO_L14P_25
G12   | 276   G12   D1.986   IO_L13N_20
AG25   | 277   AG25  D1.1055   IO_L13N_21
AK9   | 278   AK9   D1.1124   IO_L13N_22
C27   | 279   C27   D1.1193   IO_L13N_23
N14   | 280   N14   D1.31   INIT_B_0
AK26   | 281   AK26  D1.1031   IO_L8P_CC_21
AN25   | 282   AN25  D1.1307   IO_L8P_CC_25
C24   | 283   C24   D1.1169   IO_L8P_CC_23
AL23   | 284   AL23  D1.268   IO_L4N_VREF_6
F19   | 285   F19   D1.202   IO_L4N_VREF_5
A13   | 286   A13   D1.959   IO_L8P_CC_20
AJ15   | 287   AJ15  D1.278   IO_L9N_CC_6
E14   | 288   E14   D1.212   IO_L9N_CC_5
V2   | 289   V2   D1.1495   MGTTXP0_114
F2   | 290   F2   D1.1560   MGTTXP0_116
M2   | 291   M2   D1.1430   MGTTXP0_112
AD2   | 292   AD2   D1.1625   MGTTXP0_118
AD34   | 293   AD34  D1.474   IO_L5N_SM4N_13
T17   | 294   T17   D1.12   AVSS_0
AC23   | 295   AC23  D1.44   R_FUSE_0
H12   | 296   H12   D1.76   IO_L7N_A4_D20_1
D14   | 297   D14   D1.211   IO_L9P_CC_5
AL14   | 298   AL14  D1.274   IO_L7N_6
D15   | 299   D15   D1.208   IO_L7N_5
AL21   | 300   AL21  D1.294   IO_L11P_CC_6
F21   | 301   F21   D1.228   IO_L11P_CC_5
Y7   | 302   Y7   D1.818   IO_L6N_18
H24   | 303   H24   D1.890   IO_L6N_19
K6   | 304   K6   D1.404   IO_L6N_12
E33   | 305   E33   D1.338   IO_L6N_11
D22   | 306   D22   D1.233   IO_L13N_5
Y31   | 307   Y31   D1.752   IO_L6N_17
J31   | 308   J31   D1.614   IO_L6N_15
AP25   | 309   AP25  D1.1325   IO_L10N_CC_25
A26   | 310   A26   D1.1187   IO_L10N_CC_23
AD11   | 311   AD11  D1.1118   IO_L10N_CC_22
AK27   | 312   AK27  D1.1049   IO_L10N_CC_21
K9   | 313   K9   D1.980   IO_L10N_CC_20
AE12   | 314   AE12  D1.95   IO_L0N_CC_RS0_2
H20   | 315   H20   D1.146   IO_L9N_GC_3
L21   | 316   L21   D1.61   IO_L0P_A19_1
AJ29   | 317   AJ29  D1.1034   IO_L9N_CC_21
AL19   | 318   AL19  D1.298   IO_L13P_6
D21   | 319   D21   D1.232   IO_L13P_5
B31   | 320   B31   D1.1198   IO_L16P_23
AF11   | 321   AF11  D1.1129   IO_L16P_22
AE27   | 322   AE27  D1.1060   IO_L16P_21
M10   | 323   M10   D1.991   IO_L16P_20
AL29   | 324   AL29  D1.1291   IO_L0P_25
AE14   | 325   AE14  D1.102   IO_L4P_FCS_B_2
J27   | 326   J27   D1.885   IO_L4P_19
F26   | 327   F26   D1.892   IO_L7N_19
AE6   | 328   AE6   D1.820   IO_L7N_18
AH29   | 329   AH29  D1.790   IO_L19P_17
T6   | 330   T6   D1.406   IO_L7N_12
F34   | 331   F34   D1.340   IO_L7N_11
V29   | 332   V29   D1.754   IO_L7N_17
M30   | 333   M30   D1.616   IO_L7N_15
AN14   | 334   AN14  D1.1081   IO_L0P_22
AA22   | 335   AA22  D1.35   VCCO_0
AA9   | 336   AA9   D1.1088   IO_L3N_22
W11   | 337   W11   D1.848   IO_L13N_18
Y29   | 338   Y29   D1.756   IO_L8N_CC_17
AC8   | 339   AC8   D1.1091   IO_L5P_22
C23   | 340   C23   D1.1163   IO_L5P_23
K11   | 341   K11   D1.953   IO_L5P_20
AB28   | 342   AB28  D1.1025   IO_L5P_21
D16   | 343   D16   D1.207   IO_L7P_5
H8   | 344   H8   D1.950   IO_L3N_20
AH14   | 345   AH14  D1.166   IO_L3P_GC_D9_4
AK3   | 346   AK3   D1.1758   MGTAVTTTX_122
W24   | 347   W24   D1.739   IO_L0P_17
AB26   | 348   AB26  D1.1022   IO_L3N_21
AJ18   | 349   AJ18  A15.2   VCCO_6
AC14   | 350   AC14  D1.57   TMS_0
E19   | 351   E19   D1.201   IO_L4P_5
AK24   | 352   AK24  D1.267   IO_L4P_6
AF26   | 353   AF26  D1.1059   IO_L15N_21
AF33   | 354   AF33  D1.479   IO_L8P_CC_SM1P_13
AP20   | 355   AP20  D1.1335   IO_L15N_25
T30   | 356   T30   D1.643   IO_L14N_VREF_15
M32   | 357   M32   D1.365   IO_L13N_11
AG31   | 358   AG31  D1.781   IO_L14N_VREF_17
Y11   | 359   Y11   D1.847   IO_L13P_18
N34   | 360   N34   D1.367   IO_L14N_VREF_11
AH32   | 361   AH32  D1.505   IO_L14N_VREF_13
P10   | 362   P10   D1.436   IO_L14N_VREF_12
J12   | 363   J12   D1.75   IO_L7P_A5_D21_1
AJ17   | 364   AJ17  D1.297   IO_L12N_VRP_6
L33   | 365   L33   D1.364   IO_L13P_11
AP31   | 366   AP31  D1.1298   IO_L3N_25
K26   | 367   K26   D1.919   IO_L14N_VREF_19
AK33   | 368   AK33  D1.503   IO_L13N_13
T31   | 369   T31   D1.640   IO_L13P_15
AN20   | 370   AN20  D1.1334   IO_L15P_25
AL10   | 371   AL10  D1.1098   IO_L8N_CC_22
F11   | 372   F11   D1.989   IO_L15P_20
AF25   | 373   AF25  D1.1058   IO_L15P_21
AJ9   | 374   AJ9   D1.1127   IO_L15P_22
C28   | 375   C28   D1.1196   IO_L15P_23
R31   | 376   R31   D1.641   IO_L13N_15
AN18   | 377   AN18  D1.1338   IO_L17P_25
AH9   | 378   AH9   D1.1131   IO_L17P_22
C30   | 379   C30   D1.1200   IO_L17P_23
E12   | 380   E12   D1.993   IO_L17P_20
AC25   | 381   AC25  D1.1062   IO_L17P_21
V32   | 382   V32   D1.463   IO_L0P_SM8P_13
V18   | 383   V18   D1.18   VREFP_0
AH23   | 384   AH23  D1.263   IO_L2P_6
B17   | 385   B17   D1.197   IO_L2P_5
T34   | 386   T34   D1.375   IO_L18N_SM10N_11
K23   | 387   K23   D1.73   IO_L6P_A7_D23_1
F8   | 388   F8   D1.946   IO_L1N_20
AC27   | 389   AC27  D1.1018   IO_L1N_21
AA10   | 390   AA10  D1.1084   IO_L1N_22
A21   | 391   A21   D1.1156   IO_L1N_23
AL31   | 392   AL31  D1.1294   IO_L1N_25
AH3   | 393   AH3   D1.1641   MGTAVCCPLL_118
AD21   | 394   AD21  D1.54   M0_0
AM21   | 395   AM21  D1.1330   IO_L13P_25
V10   | 396   V10   D1.859   IO_L19P_18
AL20   | 397   AL20  D1.299   IO_L13N_6
C14   | 398   C14   D1.199   IO_L3P_5
AL13   | 399   AL13  D1.265   IO_L3P_6
K14   | 400   K14   D1.72   IO_L5N_A8_D24_1
E6   | 401   E6   D1.445   IO_L19P_12
AC7   | 402   AC7   D1.811   IO_L3P_18
A2   | 403   A2   D1.1705   MGTRXN0_120
AM1   | 404   AM1   D1.1770   MGTRXN0_122
A8   | 405   A8   D1.1834   MGTRXN0_124
AC34   | 406   AC34  D1.473   IO_L5P_SM4P_13
AP7   | 407   AP7   D1.1898   MGTRXN0_126
F18   | 408   F18   D1.234   IO_L14P_5
G20   | 409   G20   D1.209   IO_L8P_CC_5
AJ21   | 410   AJ21  D1.275   IO_L8P_CC_6
V7   | 411   V7   D1.844   IO_L11N_CC_18
A7   | 412   A7   D1.1844   MGTRXN1_124
AE13   | 413   AE13  D1.94   IO_L0P_CC_RS1_2
AP8   | 414   AP8   D1.1908   MGTRXN1_126
G3   | 415   G3   D1.1570   MGTAVTTRX_116
C1   | 416   C1   D1.1715   MGTRXN1_120
AP2   | 417   AP2   D1.1780   MGTRXN1_122
W17   | 418   W17   D1.6   DXN_0
U32   | 419   U32   D1.376   IO_L19P_SM9P_11
N30   | 420   N30   D1.637   IO_L11N_CC_15
L23   | 421   L23   D1.25   VBATT_0
AN32   | 422   AN32  D1.514   IO_L19P_13
D4   | 423   D4   D1.1718   MGTREFCLKN_120
AL4   | 424   AL4   D1.1783   MGTREFCLKN_122
C8   | 425   C8   D1.1847   MGTREFCLKN_124
AM7   | 426   AM7   D1.1911   MGTREFCLKN_126
H17   | 427   H17   D1.127   IO_L0P_CC_GC_3
AP26   | 428   AP26  D1.1324   IO_L10P_CC_25
AF20   | 429   AF20  D1.104   IO_L5P_FWE_B_2
AH18   | 430   AH18  D1.178   IO_L9P_CC_GC_4
AN4   | 431   AN4   D1.1796   MGTTXP1_122
AE22   | 432   AE22  D1.100   IO_L3P_A21_2
H1   | 433   H1   D1.1575   MGTRXN0_116
W18   | 434   W18   D1.5   DXP_0
AF21   | 435   AF21  D1.105   IO_L5N_CSO_B_2
AE26   | 436   AE26  D1.1061   IO_L16N_21
L9   | 437   L9   D1.992   IO_L16N_20
A31   | 438   A31   D1.1199   IO_L16N_23
AE11   | 439   AE11  D1.1130   IO_L16N_22
AM22   | 440   AM22  D1.1337   IO_L16N_25
AH19   | 441   AH19  D1.165   IO_L2N_GC_D10_4
K33   | 442   K33   D1.360   IO_L11P_CC_SM14P_11
R24   | 443   R24   D1.928   IO_L19P_19
L16   | 444   L16   D1.64   IO_L1N_A16_1
AB3   | 445   AB3   D1.1511   MGTAVCCPLL_114
K3   | 446   K3   D1.1576   MGTAVCCPLL_116
K22   | 447   K22   D1.74   IO_L6N_A6_D22_1
T3   | 448   T3   D1.1446   MGTAVCCPLL_112
AF16   | 449   AF16  D1.110   IO_L8P_D3_2
AK8   | 450   AK8   D1.1123   IO_L13P_22
D26   | 451   D26   D1.1192   IO_L13P_23
G11   | 452   G11   D1.985   IO_L13P_20
AF24   | 453   AF24  D1.1054   IO_L13P_21
T1   | 454   T1   D1.1462   MGTRXP1_112
AJ24   | 455   AJ24  D1.260   IO_L0N_6
J14   | 456   J14   D1.143   IO_L8P_GC_3
K19   | 457   K19   D1.138   IO_L5N_GC_3
N22   | 458   N22   D1.33   CS_B_0
AG15   | 459   AG15  D1.171   IO_L5N_GC_4
B15   | 460   B15   D1.194   IO_L0N_5
AJ26   | 461   AJ26  D1.1051   IO_L11N_CC_21
AA6   | 462   AA6   D1.817   IO_L6P_18
H25   | 463   H25   D1.889   IO_L6P_19
AK21   | 464   AK21  D1.295   IO_L11N_CC_6
E32   | 465   E32   D1.337   IO_L6P_11
AP21   | 466   AP21  D1.1341   IO_L18N_25
AB30   | 467   AB30  D1.772   IO_L10P_CC_17
D30   | 468   D30   D1.1203   IO_L18N_23
AH8   | 469   AH8   D1.1134   IO_L18N_22
AD25   | 470   AD25  D1.1065   IO_L18N_21
W31   | 471   W31   D1.751   IO_L6P_17
T10   | 472   T10   D1.439   IO_L16P_12
AL34   | 473   AL34  D1.508   IO_L16P_13
AJ31   | 474   AJ31  D1.784   IO_L16P_17
U27   | 475   U27   D1.646   IO_L16P_15
AJ7   | 476   AJ7   D1.853   IO_L16P_18
P26   | 477   P26   D1.922   IO_L16P_19
AK12   | 478   AK12  D1.261   IO_L1P_6
J19   | 479   J19   D1.134   IO_L3N_GC_3
AH1   | 480   AH1   D1.1657   MGTRXP1_118
A14   | 481   A14   D1.196   IO_L1N_5
B16   | 482   B16   D1.193   IO_L0P_5
AE2   | 483   AE2   D1.1629   MGTTXN0_118
AJ12   | 484   AJ12  D1.262   IO_L1N_6
G2   | 485   G2   D1.1564   MGTTXN0_116
W2   | 486   W2   D1.1499   MGTTXN0_114
N2   | 487   N2   D1.1434   MGTTXN0_112
J21   | 488   J21   D1.142   IO_L7N_GC_3
AH30   | 489   AH30  D1.789   IO_L18N_17
AB10   | 490   AB10  D1.1083   IO_L1P_22
B21   | 491   B21   D1.1155   IO_L1P_23
F9   | 492   F9   D1.945   IO_L1P_20
AB27   | 493   AB27  D1.1017   IO_L1P_21
C17   | 494   C17   D1.203   IO_L5P_5
AM31   | 495   AM31  D1.1293   IO_L1P_25
A33   | 496   A33   D1.326   IO_L0N_11
M5   | 497   M5   D1.392   IO_L0N_12
T26   | 498   T26   D1.651   IO_L18N_15
F29   | 499   F29   D1.602   IO_L0N_15
V24   | 500   V24   D1.740   IO_L0N_17
AC5   | 501   AC5   D1.806   IO_L0N_18
L24   | 502   L24   D1.878   IO_L0N_19
W6   | 503   W6   D1.821   IO_L8P_CC_18
G27   | 504   G27   D1.893   IO_L8P_CC_19
J6   | 505   J6   D1.407   IO_L8P_CC_12
AF18   | 506   AF18  D1.176   IO_L8P_CC_GC_4
AD14   | 507   AD14  D1.60   TDO_0
Y28   | 508   Y28   D1.755   IO_L8P_CC_17
N29   | 509   N29   D1.617   IO_L8P_CC_15
AK11   | 510   AK11  D1.1119   IO_L11P_CC_22
B25   | 511   B25   D1.1188   IO_L11P_CC_23
B13   | 512   B13   D1.981   IO_L11P_CC_20
AH27   | 513   AH27  D1.1050   IO_L11P_CC_21
AK23   | 514   AK23  D1.271   IO_L6P_6
E21   | 515   E21   D1.205   IO_L6P_5
B4   | 516   B4   D1.1690   MGTTXP0_120
AK2   | 517   AK2   D1.1755   MGTTXP0_122
AA33   | 518   AA33  D1.468   IO_L2N_SM6N_13
AN5   | 519   AN5   D1.1883   MGTTXP0_126
C33   | 520   C33   D1.328   IO_L1N_11
N7   | 521   N7   D1.394   IO_L1N_12
F30   | 522   F30   D1.604   IO_L1N_15
AK6   | 523   AK6   D1.858   IO_L18N_18
W26   | 524   W26   D1.742   IO_L1N_17
L26   | 525   L26   D1.880   IO_L1N_19
AB7   | 526   AB7   D1.808   IO_L1N_18
N25   | 527   N25   D1.927   IO_L18N_19
K7   | 528   K7   D1.403   IO_L6P_12
AC15   | 529   AC15  D1.58   TDI_0
Y26   | 530   Y26   D1.741   IO_L1P_17
R34   | 531   R34   D1.371   IO_L16N_SM12N_11
AE19   | 532   AE19  D1.112   IO_L9P_D1_FS1_2
K27   | 533   K27   D1.918   IO_L14P_19
AE34   | 534   AE34  D1.482   IO_L9N_CC_SM0N_13
A11   | 535   A11   A10.1   GND
G8   | 536   G8   D1.949   IO_L3P_20
AB25   | 537   AB25  D1.1021   IO_L3P_21
AA8   | 538   AA8   D1.1087   IO_L3P_22
N9   | 539   N9   D1.996   IO_L18N_20
H10   | 540   H10   D1.957   IO_L7P_20
AP30   | 541   AP30  D1.1297   IO_L3P_25
AC10   | 542   AC10  D1.1095   IO_L7P_22
A23   | 543   A23   D1.1167   IO_L7P_23
AG16   | 544   AG16  D1.175   IO_L7N_GC_VRP_4
P32   | 545   P32   D1.368   IO_L15P_SM13P_11
J16   | 546   J16   D1.135   IO_L4P_GC_3
AG21   | 547   AG21  D1.168   IO_L4P_GC_4
AA28   | 548   AA28  D1.1026   IO_L5N_21
H28   | 549   H28   D1.895   IO_L9P_CC_19
AE7   | 550   AE7   D1.823   IO_L9P_CC_18
K31   | 551   K31   D1.619   IO_L9P_CC_15
AN27   | 552   AN27  D1.1304   IO_L6N_25
N23   | 553   N23   D1.34   RDWR_B_0
H34   | 554   H34   D1.343   IO_L9P_CC_11
AM11   | 555   AM11  D1.1094   IO_L6N_22
AH28   | 556   AH28  D1.1028   IO_L6N_21
R7   | 557   R7   D1.409   IO_L9P_CC_12
AF15   | 558   AF15  D1.106   IO_L6P_D7_2
AK31   | 559   AK31  D1.785   IO_L16N_17
J20   | 560   J20   D1.141   IO_L7P_GC_3
W34   | 561   W34   D1.465   IO_L1P_SM7P_13
AH10   | 562   AH10  D1.1132   IO_L17N_22
U33   | 563   U33   D1.374   IO_L18P_SM10P_11
D1   | 564   D1   D1.1722   MGTRXP1_120
H7   | 565   H7   D1.429   IO_L11P_CC_12
AF34   | 566   AF34  D1.481   IO_L9P_CC_SM0P_13
A15   | 567   A15   D1.195   IO_L1P_5
AJ4   | 568   AJ4   D1.1762   MGTAVCC_122
B22   | 569   B22   D1.1160   IO_L3N_23
D5   | 570   D5   D1.1697   MGTAVCC_120
AL15   | 571   AL15  D1.273   IO_L7P_6
AL8   | 572   AL8   D1.1890   MGTAVCC_126
C7   | 573   C7   D1.1826   MGTAVCC_124
AH13   | 574   AH13  D1.167   IO_L3N_GC_D8_4
P7   | 575   P7   D1.401   IO_L5P_12
F33   | 576   F33   D1.335   IO_L5P_11
V28   | 577   V28   D1.749   IO_L5P_17
H30   | 578   H30   D1.611   IO_L5P_15
G25   | 579   G25   D1.887   IO_L5P_19
AD4   | 580   AD4   D1.815   IO_L5P_18
AG17   | 581   AG17  D1.179   IO_L9N_CC_GC_4
AM28   | 582   AM28  D1.1306   IO_L7N_25
AN22   | 583   AN22  D1.1336   IO_L16P_25
A24   | 584   A24   D1.1168   IO_L7N_23
AL24   | 585   AL24  D1.1327   IO_L11N_CC_25
T8   | 586   T8   D1.427   IO_L10P_CC_12
AH34   | 587   AH34  D1.496   IO_L10P_CC_13
C13   | 588   C13   D1.982   IO_L11N_CC_20
P31   | 589   P31   D1.634   IO_L10P_CC_15
AJ11   | 590   AJ11  D1.1120   IO_L11N_CC_22
C25   | 591   C25   D1.1189   IO_L11N_CC_23
AG5   | 592   AG5   D1.841   IO_L10P_CC_18
E28   | 593   E28   D1.910   IO_L10P_CC_19
AA12   | 594   AA12  C1.2   VCCINT
B30   | 595   B30   D1.1205   IO_L19N_23
AG28   | 596   AG28  D1.1027   IO_L6P_21
AJ14   | 597   AJ14  D1.269   IO_L5P_6
A19   | 598   A19   D1.1165   IO_L6P_23
AM12   | 599   AM12  D1.1093   IO_L6P_22
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[Model Data]
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[End Model Data]
[End Package Model]
| Models and submodels in the file (6): LVCMOS25_F_12 (I/O), LVCMOS25_S_12 (I/O), LVDCI_25 (I/O), SSTL2_II_DCI (I/O), SSTL2_I_DCI_I (Input), SSTL2_I_DCI_O (Output)
